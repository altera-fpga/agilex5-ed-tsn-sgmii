// Include the UVM_SW/HW_Access UDP definition file
`include "lib_uvm.rdl"

// Module Definition
addrmap user_csr_space {
        name = "user_csr_space";
        desc = "user_csr_space";
        addressing = fullalign;
        alignment = 4;
        
// No Signals Defined
        
// Register Definition
        reg STATUS_REG {
                name = "STATUS_REG";
                desc = "My status Register";
                regwidth = 32;
                accesswidth = 32;
                field {
                        name = "Reserved";
                        desc = "Reserved";
                        UVM_SW_Access = "RO";
                        UVM_HW_Access = "NA";
                        reset = 25'h0;
                } Reserved[31:7];
                field {
                        name = "op_speed";
                        desc = "MRPHY Op speed - 2.5G";
                        UVM_SW_Access = "RO";
                        UVM_HW_Access = "WO";
                        reset = 3'b100;
                } op_speed[6:4];
                field {
                        name = "rx_block_lock";
                        desc = "Asserted when 66b block alignment is finished on all PCS virtual lanes";
                        UVM_SW_Access = "RO";
                        UVM_HW_Access = "WO";
                        reset = 1'b0;
                } rx_block_lock[3:3];
                field {
                        name = "tx_ready";
                        desc = "Asserted when MRPHY TX is ready";
                        UVM_SW_Access = "RO";
                        UVM_HW_Access = "WO";
                        reset = 1'b0;
                } tx_ready[2:2];
                field {
                        name = "rx_ready";
                        desc = "Asserted when MRPHY RX is ready";
                        UVM_SW_Access = "RO";
                        UVM_HW_Access = "WO";
                        reset = 1'b0;
                } rx_ready[1:1];
                field {
                        name = "mrphy_pll_lock";
                        desc = "Asserted when PLL in MRPHY soft logic is locked";
                        UVM_SW_Access = "RO";
                        UVM_HW_Access = "WO";
                        reset = 1'b0;
                } mrphy_pll_lock[0:0];
        };
        reg RESET_CTRL {
                name = "RESET_CTRL";
                desc = "Reset Control Register";
                regwidth = 32;
                accesswidth = 32;
                field {
                        name = "Reserved";
                        desc = "Reserved";
                        UVM_SW_Access = "RO";
                        UVM_HW_Access = "NA";
                        reset = 29'b0;
                } Reserved[31:3];
                field {
                        name = "i_rx_rst_n";
                        desc = "Reset MRPHY RX path. 
                               Self cleared on o_rx_rst_ack_n";
                        UVM_SW_Access = "RW";
                        UVM_HW_Access = "RW";
                        reset = 1'b1;
                } i_rx_rst_n[2:2];
                field {
                        name = "i_tx_rst_n";
                        desc = "Reset MRPHY TX path. 
                               Self cleared on o_rx_rst_ack_n";
                        UVM_SW_Access = "RW";
                        UVM_HW_Access = "RW";
                        reset = 1'b1;
                } i_tx_rst_n[1:1];
                field {
                        name = "i_rst_n";
                        desc = "Global reset to MRPHY. 
                               Self cleared on o_rst_ack_n";
                        UVM_SW_Access = "RW";
                        UVM_HW_Access = "RW";
                        reset = 1'b1;
                } i_rst_n[0:0];
        };
        reg DELAY_TX {
                name = "DELAY_TX";
                desc = "User Logic Delay Register";
                regwidth = 32;
                accesswidth = 32;
                field {
                        name = "Reserved";
                        desc = "Reserved";
                        UVM_SW_Access = "RO";
                        UVM_HW_Access = "NA";
                        reset = 28'b0;
                } Reserved[31:4];
                field {
                        name = "Additional_User_added_delay1";
                        desc = "Additional GMII Datapath Delay added by used if timing issue arise in number of clock cycles gmii8_tx_clkout";
                        UVM_SW_Access = "RO";
                        UVM_HW_Access = "RO";
                        reset = 4'b0;
                } Additional_User_added_delay1[3:0];
        };
        reg DELAY_RX {
                name = "DELAY_RX";
                desc = "User Logic Delay Register";
                regwidth = 32;
                accesswidth = 32;
                field {
                        name = "Reserved";
                        desc = "Reserved";
                        UVM_SW_Access = "RO";
                        UVM_HW_Access = "NA";
                        reset = 28'b0;
                } Reserved[31:4];
                field {
                        name = "Additional_User_added_delay1";
                        desc = "Additional GMII Datapath Delay added by used if timing issue arise in number of clock cycles gmii8_rx_clkout";
                        UVM_SW_Access = "RO";
                        UVM_HW_Access = "RO";
                        reset = 4'b0;
                } Additional_User_added_delay1[3:0];
        };
        reg ERROR {
                name = "ERROR";
                desc = "Error Status Register";
                regwidth = 32;
                accesswidth = 32;
                field {
                        name = "Reserved";
                        desc = "Reserved";
                        UVM_SW_Access = "RO";
                        UVM_HW_Access = "NA";
                        reset = 31'b0;
                } Reserved[31:1];
                field {
                        name = "Unsupported_Speed_Error1";
                        desc = "Assert high when XGMAC publish unsupported speeds. 
                               SW to clear these bits once addressed";
                        UVM_SW_Access = "RW";
                        UVM_HW_Access = "RO";
                        reset = 1'b0;
                } Unsupported_Speed_Error1[0:0];
        };
        reg DR_STATUS {
                name = "DR_STATUS";
                desc = "DR Error Status Register";
                regwidth = 32;
                accesswidth = 32;
                field {
                        name = "Reserved1";
                        desc = "Reserved";
                        UVM_SW_Access = "RO";
                        UVM_HW_Access = "NA";
                        reset = 15'b0;
                } Reserved1[31:17];
                field {
                        name = "dr_new_cfg_applied";
                        desc = "Comes from DR Controller when new profile is applied";
                        UVM_SW_Access = "RO";
                        UVM_HW_Access = "WO";
                        reset = 1'b0;
                } dr_new_cfg_applied[16:16];
                field {
                        name = "Reserved2";
                        desc = "Reserved";
                        UVM_SW_Access = "RO";
                        UVM_HW_Access = "NA";
                        reset = 15'b0;
                } Reserved2[15:1];
                field {
                        name = "dr_error_status";
                        desc = "Comes from DR Controller";
                        UVM_SW_Access = "RW";
                        UVM_HW_Access = "RW";
                        reset = 1'b0;
                } dr_error_status[0:0];
        };
        reg XCVR_MODE {
                name = "XCVR_MODE";
                desc = "My Configuration Register";
                regwidth = 32;
                accesswidth = 32;
                field {
                        name = "Reserved";
                        desc = "Reserved";
                        UVM_SW_Access = "RO";
                        UVM_HW_Access = "NA";
                        reset = 30'b0;
                } Reserved[31:2];
                field {
                        name = "xcvr_mode";
                        desc = "For MRPHY";
                        UVM_SW_Access = "RW";
                        UVM_HW_Access = "RO";
                        reset = 2'b0;
                } xcvr_mode[1:0];
        };
        reg PHY0_TX_DELAY {
                name = "PHY0_TX_DELAY";
                desc = "PHY Path Delay Register";
                regwidth = 32;
                accesswidth = 32;
                field {
                        name = "Reserved";
                        desc = "Reserved";
                        UVM_SW_Access = "RO";
                        UVM_HW_Access = "NA";
                        reset = 16'b0;
                } Reserved[31:16];
                field {
                        name = "Any_PHY_Delay";
                        desc = "FPGA IO to Marvell PHY";
                        UVM_SW_Access = "RO";
                        UVM_HW_Access = "NA";
                        reset = 16'b0;
                } Any_PHY_Delay[15:0];
        };
        reg PHY0_RX_DELAY {
                name = "PHY0_RX_DELAY";
                desc = "PHY Path Delay Register";
                regwidth = 32;
                accesswidth = 32;
                field {
                        name = "Reserved";
                        desc = "Reserved";
                        UVM_SW_Access = "RO";
                        UVM_HW_Access = "NA";
                        reset = 16'b0;
                } Reserved[31:16];
                field {
                        name = "Any_PHY_Delay";
                        desc = "FPGA IO to Marvell PHY";
                        UVM_SW_Access = "RO";
                        UVM_HW_Access = "NA";
                        reset = 16'b0;
                } Any_PHY_Delay[15:0];
        };
        reg Reserved {
                name = "Reserved";
                desc = "Reserved";
                regwidth = 32;
                accesswidth = 32;
                field {
                        name = "Reserved";
                        desc = "Added to make the address bus width 7 bits, No functional use";
                        UVM_SW_Access = "RO";
                        UVM_HW_Access = "NA";
                        reset = 32'b0;
                } Reserved[31:0];
        };
// 
//=================================================================================
// Declare instances of all the registers and set their addresses
//=================================================================================
//(Component)    REG_NAME                INSTANCE_NAME               Address Offset
              STATUS_REG                STATUS_REG                 @0x00          ; 
              RESET_CTRL                RESET_CTRL                 @0x04          ; 
              DELAY_TX                  DELAY_TX                   @0x08          ; 
              DELAY_RX                  DELAY_RX                   @0x0C          ; 
              ERROR                     ERROR                      @0x10          ; 
              DR_STATUS                 DR_STATUS                  @0x14          ; 
              XCVR_MODE                 XCVR_MODE                  @0x18          ; 
              PHY0_TX_DELAY             PHY0_TX_DELAY              @0x1C          ; 
              PHY0_RX_DELAY             PHY0_RX_DELAY              @0x20          ; 
              Reserved                  Reserved                   @0x40          ; 
// Assigning the interrupt's enable signal/register
};
