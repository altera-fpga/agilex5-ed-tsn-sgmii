// Include the UVM_SW/HW_Access UDP definition file
`include "lib_uvm.rdl"

// Module Definition
addrmap user_csr_space {
        name = "user_csr_space";
        desc = "user_csr_space";
        addressing = fullalign;
        alignment = 4;
        
// No Signals Defined
        
// Register Definition
        reg STATUS_REG {
                name = "STATUS_REG";
                desc = "Status Register";
                regwidth = 32;
                accesswidth = 32;
                field {
                        name = "Reserved";
                        desc = "Reserved";
                        UVM_SW_Access = "RO";
                        UVM_HW_Access = "NA";
                        reset = 11'b0;
                } Reserved[31:21];
                field {
                        name = "PHY_2_op_speed";
                        desc = "PHY2 -MRPHY Op speed - 2.5G";
                        UVM_SW_Access = "RO";
                        UVM_HW_Access = "WO";
                        reset = 3'b100;
                } PHY_2_op_speed[20:18];
                field {
                        name = "PHY_2_rx_block_lock";
                        desc = "PHY2 -Asserted when 66b block alignment is finished on all PCS virtual lanes";
                        UVM_SW_Access = "RO";
                        UVM_HW_Access = "WO";
                        reset = 1'b0;
                } PHY_2_rx_block_lock[17:17];
                field {
                        name = "PHY_2_tx_ready";
                        desc = "PHY2 -Asserted when MRPHY TX is ready";
                        UVM_SW_Access = "RO";
                        UVM_HW_Access = "WO";
                        reset = 1'b0;
                } PHY_2_tx_ready[16:16];
                field {
                        name = "PHY_2_rx_ready";
                        desc = "PHY2 -Asserted when MRPHY RX is ready";
                        UVM_SW_Access = "RO";
                        UVM_HW_Access = "WO";
                        reset = 1'b0;
                } PHY_2_rx_ready[15:15];
                field {
                        name = "PHY_2_mrphy_pll_lock";
                        desc = "PHY2 -Asserted when PLL in MRPHY soft logic is locked";
                        UVM_SW_Access = "RO";
                        UVM_HW_Access = "WO";
                        reset = 1'b0;
                } PHY_2_mrphy_pll_lock[14:14];
                field {
                        name = "PHY_1_op_speed";
                        desc = "PHY1 -MRPHY Op speed - 2.5G";
                        UVM_SW_Access = "RO";
                        UVM_HW_Access = "WO";
                        reset = 3'b100;
                } PHY_1_op_speed[13:11];
                field {
                        name = "PHY_1_rx_block_lock";
                        desc = "PHY1 -Asserted when 66b block alignment is finished on all PCS virtual lanes";
                        UVM_SW_Access = "RO";
                        UVM_HW_Access = "WO";
                        reset = 1'b0;
                } PHY_1_rx_block_lock[10:10];
                field {
                        name = "PHY_1_tx_ready";
                        desc = "PHY1 -Asserted when MRPHY TX is ready";
                        UVM_SW_Access = "RO";
                        UVM_HW_Access = "WO";
                        reset = 1'b0;
                } PHY_1_tx_ready[9:9];
                field {
                        name = "PHY_1_rx_ready";
                        desc = "PHY1 -Asserted when MRPHY RX is ready";
                        UVM_SW_Access = "RO";
                        UVM_HW_Access = "WO";
                        reset = 1'b0;
                } PHY_1_rx_ready[8:8];
                field {
                        name = "PHY_1_mrphy_pll_lock";
                        desc = "PHY1 -Asserted when PLL in MRPHY soft logic is locked";
                        UVM_SW_Access = "RO";
                        UVM_HW_Access = "WO";
                        reset = 1'b0;
                } PHY_1_mrphy_pll_lock[7:7];
                field {
                        name = "PHY_0_op_speed";
                        desc = "PHY0 -MRPHY Op speed - 2.5G";
                        UVM_SW_Access = "RO";
                        UVM_HW_Access = "WO";
                        reset = 3'b100;
                } PHY_0_op_speed[6:4];
                field {
                        name = "PHY_0_rx_block_lock";
                        desc = "PHY0 -Asserted when 66b block alignment is finished on all PCS virtual lanes";
                        UVM_SW_Access = "RO";
                        UVM_HW_Access = "WO";
                        reset = 1'b0;
                } PHY_0_rx_block_lock[3:3];
                field {
                        name = "PHY_0_tx_ready";
                        desc = "PHY0 -Asserted when MRPHY TX is ready";
                        UVM_SW_Access = "RO";
                        UVM_HW_Access = "WO";
                        reset = 1'b0;
                } PHY_0_tx_ready[2:2];
                field {
                        name = "PHY_0_rx_ready";
                        desc = "PHY0 -Asserted when MRPHY RX is ready";
                        UVM_SW_Access = "RO";
                        UVM_HW_Access = "WO";
                        reset = 1'b0;
                } PHY_0_rx_ready[1:1];
                field {
                        name = "PHY_0_mrphy_pll_lock";
                        desc = "PHY0 - Asserted when PLL in MRPHY soft logic is locked";
                        UVM_SW_Access = "RO";
                        UVM_HW_Access = "WO";
                        reset = 1'b0;
                } PHY_0_mrphy_pll_lock[0:0];
        };
        reg RESET_CTRL {
                name = "RESET_CTRL";
                desc = "Reset Control Register";
                regwidth = 32;
                accesswidth = 32;
                field {
                        name = "Reserved";
                        desc = "Reserved";
                        UVM_SW_Access = "RO";
                        UVM_HW_Access = "NA";
                        reset = 23'b0;
                } Reserved[31:9];
                field {
                        name = "PHY_2_i_rx_rst_n";
                        desc = "PHY2 -Reset MRPHY RX path. 
                               Self cleared on o_rx_rst_ack_n";
                        UVM_SW_Access = "RW";
                        UVM_HW_Access = "RW";
                        reset = 1'b1;
                } PHY_2_i_rx_rst_n[8:8];
                field {
                        name = "PHY_2_i_tx_rst_n";
                        desc = "PHY2 -Reset MRPHY TX path. 
                               Self cleared on o_rx_rst_ack_n";
                        UVM_SW_Access = "RW";
                        UVM_HW_Access = "RW";
                        reset = 1'b1;
                } PHY_2_i_tx_rst_n[7:7];
                field {
                        name = "PHY_2_i_rst_n";
                        desc = "PHY2 -Global reset to MRPHY. 
                               Self cleared on o_rst_ack_n";
                        UVM_SW_Access = "RW";
                        UVM_HW_Access = "RW";
                        reset = 1'b1;
                } PHY_2_i_rst_n[6:6];
                field {
                        name = "PHY_1_i_rx_rst_n";
                        desc = "PHY1 -Reset MRPHY RX path. 
                               Self cleared on o_rx_rst_ack_n";
                        UVM_SW_Access = "RW";
                        UVM_HW_Access = "RW";
                        reset = 1'b1;
                } PHY_1_i_rx_rst_n[5:5];
                field {
                        name = "PHY_1_i_tx_rst_n";
                        desc = "PHY1 -Reset MRPHY TX path. 
                               Self cleared on o_rx_rst_ack_n";
                        UVM_SW_Access = "RW";
                        UVM_HW_Access = "RW";
                        reset = 1'b1;
                } PHY_1_i_tx_rst_n[4:4];
                field {
                        name = "PHY_1_i_rst_n";
                        desc = "PHY1 -Global reset to MRPHY. 
                               Self cleared on o_rst_ack_n";
                        UVM_SW_Access = "RW";
                        UVM_HW_Access = "RW";
                        reset = 1'b1;
                } PHY_1_i_rst_n[3:3];
                field {
                        name = "PHY_0_i_rx_rst_n";
                        desc = "PHY0 -Reset MRPHY RX path. 
                               Self cleared on o_rx_rst_ack_n";
                        UVM_SW_Access = "RW";
                        UVM_HW_Access = "RW";
                        reset = 1'b1;
                } PHY_0_i_rx_rst_n[2:2];
                field {
                        name = "PHY_0_i_tx_rst_n";
                        desc = "PHY0 -Reset MRPHY TX path. 
                               Self cleared on o_rx_rst_ack_n";
                        UVM_SW_Access = "RW";
                        UVM_HW_Access = "RW";
                        reset = 1'b1;
                } PHY_0_i_tx_rst_n[1:1];
                field {
                        name = "PHY_0_i_rst_n";
                        desc = "PHY0 -Global reset to MRPHY. 
                               Self cleared on o_rst_ack_n";
                        UVM_SW_Access = "RW";
                        UVM_HW_Access = "RW";
                        reset = 1'b1;
                } PHY_0_i_rst_n[0:0];
        };
        reg DELAY_TX {
                name = "DELAY_TX";
                desc = "User Logic Delay Register";
                regwidth = 32;
                accesswidth = 32;
                field {
                        name = "Reserved";
                        desc = "Reserved";
                        UVM_SW_Access = "RO";
                        UVM_HW_Access = "NA";
                        reset = 20'b0;
                } Reserved[31:12];
                field {
                        name = "Additional_User_added_delay1";
                        desc = "Future - In concurrent use case";
                        UVM_SW_Access = "RO";
                        UVM_HW_Access = "RO";
                        reset = 4'b0;
                } Additional_User_added_delay1[11:8];
                field {
                        name = "Additional_User_added_delay2";
                        desc = "Future - In concurrent use case";
                        UVM_SW_Access = "RO";
                        UVM_HW_Access = "RO";
                        reset = 4'b0;
                } Additional_User_added_delay2[7:4];
                field {
                        name = "Additional_User_added_delay3";
                        desc = "Additional GMII Datapath Delay added by used if timing issue arise in number of clock cycles gmii8_tx_clkout";
                        UVM_SW_Access = "RO";
                        UVM_HW_Access = "RO";
                        reset = 4'b0;
                } Additional_User_added_delay3[3:0];
        };
        reg DELAY_RX {
                name = "DELAY_RX";
                desc = "User Logic Delay Register";
                regwidth = 32;
                accesswidth = 32;
                field {
                        name = "Reserved";
                        desc = "Reserved";
                        UVM_SW_Access = "RO";
                        UVM_HW_Access = "NA";
                        reset = 20'b0;
                } Reserved[31:12];
                field {
                        name = "Additional_User_added_delay1";
                        desc = "Future - In concurrent use case";
                        UVM_SW_Access = "RO";
                        UVM_HW_Access = "RO";
                        reset = 4'b0;
                } Additional_User_added_delay1[11:8];
                field {
                        name = "Additional_User_added_delay2";
                        desc = "Future - In concurrent use case";
                        UVM_SW_Access = "RO";
                        UVM_HW_Access = "RO";
                        reset = 4'b0;
                } Additional_User_added_delay2[7:4];
                field {
                        name = "Additional_User_added_delay3";
                        desc = "Additional GMII Datapath Delay added by used if timing issue arise in number of clock cycles gmii8_rx_clkout";
                        UVM_SW_Access = "RO";
                        UVM_HW_Access = "RO";
                        reset = 4'b0;
                } Additional_User_added_delay3[3:0];
        };
        reg ERROR {
                name = "ERROR";
                desc = "Error Status Register";
                regwidth = 32;
                accesswidth = 32;
                field {
                        name = "Reserved";
                        desc = "Reserved";
                        UVM_SW_Access = "RO";
                        UVM_HW_Access = "NA";
                        reset = 29'b0;
                } Reserved[31:3];
                field {
                        name = "Unsupported_Speed_Error1";
                        desc = "For concurrent Usecases";
                        UVM_SW_Access = "RW";
                        UVM_HW_Access = "RO";
                        reset = 2'b0;
                } Unsupported_Speed_Error1[2:1];
                field {
                        name = "Unsupported_Speed_Error2";
                        desc = "Assert high when XGMAC publish unsupported speeds. 
                               SW to clear these bits once addressed";
                        UVM_SW_Access = "RW";
                        UVM_HW_Access = "RO";
                        reset = 1'b0;
                } Unsupported_Speed_Error2[0:0];
        };
        reg DR_STATUS {
                name = "DR_STATUS";
                desc = "DR Error Status Register";
                regwidth = 32;
                accesswidth = 32;
                field {
                        name = "Reserved1";
                        desc = "Reserved";
                        UVM_SW_Access = "RO";
                        UVM_HW_Access = "NA";
                        reset = 15'b0;
                } Reserved1[31:17];
                field {
                        name = "dr_new_cfg_applied";
                        desc = "Comes from DR Controller when new profile is applied";
                        UVM_SW_Access = "RO";
                        UVM_HW_Access = "WO";
                        reset = 1'b0;
                } dr_new_cfg_applied[16:16];
                field {
                        name = "Reserved2";
                        desc = "Reserved";
                        UVM_SW_Access = "RO";
                        UVM_HW_Access = "NA";
                        reset = 15'b0;
                } Reserved2[15:1];
                field {
                        name = "dr_error_status";
                        desc = "Comes from DR Controller";
                        UVM_SW_Access = "RW";
                        UVM_HW_Access = "RW";
                        reset = 1'b0;
                } dr_error_status[0:0];
        };
        reg XCVR_MODE {
                name = "XCVR_MODE";
                desc = "My Configuration Register";
                regwidth = 32;
                accesswidth = 32;
                field {
                        name = "Reserved";
                        desc = "Reserved";
                        UVM_SW_Access = "RO";
                        UVM_HW_Access = "NA";
                        reset = 26'b0;
                } Reserved[31:6];
                field {
                        name = "xcvr_mode_phy2";
                        desc = "For MRPHY2";
                        UVM_SW_Access = "RW";
                        UVM_HW_Access = "RO";
                        reset = 2'b0;
                } xcvr_mode_phy2[5:4];
                field {
                        name = "xcvr_mode_phy1";
                        desc = "For MRPHY2";
                        UVM_SW_Access = "RW";
                        UVM_HW_Access = "RO";
                        reset = 2'b0;
                } xcvr_mode_phy1[3:2];
                field {
                        name = "xcvr_mode_phy0";
                        desc = "For MRPHY2";
                        UVM_SW_Access = "RW";
                        UVM_HW_Access = "RO";
                        reset = 2'b0;
                } xcvr_mode_phy0[1:0];
        };
        reg PHY0_TX_DELAY {
                name = "PHY0_TX_DELAY";
                desc = "PHY Path Delay Register";
                regwidth = 32;
                accesswidth = 32;
                field {
                        name = "Reserved";
                        desc = "Reserved";
                        UVM_SW_Access = "RO";
                        UVM_HW_Access = "NA";
                        reset = 16'b0;
                } Reserved[31:16];
                field {
                        name = "Any_PHY_Delay";
                        desc = "FPGA IO to Marvell PHY";
                        UVM_SW_Access = "RO";
                        UVM_HW_Access = "NA";
                        reset = 16'b0;
                } Any_PHY_Delay[15:0];
        };
        reg PHY0_RX_DELAY {
                name = "PHY0_RX_DELAY";
                desc = "PHY Path Delay Register";
                regwidth = 32;
                accesswidth = 32;
                field {
                        name = "Reserved";
                        desc = "Reserved";
                        UVM_SW_Access = "RO";
                        UVM_HW_Access = "NA";
                        reset = 16'b0;
                } Reserved[31:16];
                field {
                        name = "Any_PHY_Delay";
                        desc = "FPGA IO to Marvell PHY";
                        UVM_SW_Access = "RO";
                        UVM_HW_Access = "NA";
                        reset = 16'b0;
                } Any_PHY_Delay[15:0];
        };
        reg PHY1_TX_DELAY {
                name = "PHY1_TX_DELAY";
                desc = "PHY Path Delay Register";
                regwidth = 32;
                accesswidth = 32;
                field {
                        name = "Reserved";
                        desc = "Reserved";
                        UVM_SW_Access = "RO";
                        UVM_HW_Access = "NA";
                        reset = 16'b0;
                } Reserved[31:16];
                field {
                        name = "Any_PHY_Delay";
                        desc = "FPGA IO to Marvell PHY";
                        UVM_SW_Access = "RO";
                        UVM_HW_Access = "NA";
                        reset = 16'b0;
                } Any_PHY_Delay[15:0];
        };
        reg PHY1_RX_DELAY {
                name = "PHY1_RX_DELAY";
                desc = "PHY Path Delay Register";
                regwidth = 32;
                accesswidth = 32;
                field {
                        name = "Reserved";
                        desc = "Reserved";
                        UVM_SW_Access = "RO";
                        UVM_HW_Access = "NA";
                        reset = 16'b0;
                } Reserved[31:16];
                field {
                        name = "Any_PHY_Delay";
                        desc = "FPGA IO to Marvell PHY";
                        UVM_SW_Access = "RO";
                        UVM_HW_Access = "NA";
                        reset = 16'b0;
                } Any_PHY_Delay[15:0];
        };
        reg PHY2_TX_DELAY {
                name = "PHY2_TX_DELAY";
                desc = "PHY Path Delay Register";
                regwidth = 32;
                accesswidth = 32;
                field {
                        name = "Reserved";
                        desc = "Reserved";
                        UVM_SW_Access = "RO";
                        UVM_HW_Access = "NA";
                        reset = 16'b0;
                } Reserved[31:16];
                field {
                        name = "Any_PHY_Delay";
                        desc = "FPGA IO to Marvell PHY";
                        UVM_SW_Access = "RO";
                        UVM_HW_Access = "NA";
                        reset = 16'b0;
                } Any_PHY_Delay[15:0];
        };
        reg PHY2_RX_DELAY {
                name = "PHY2_RX_DELAY";
                desc = "PHY Path Delay Register";
                regwidth = 32;
                accesswidth = 32;
                field {
                        name = "Reserved";
                        desc = "Reserved";
                        UVM_SW_Access = "RO";
                        UVM_HW_Access = "NA";
                        reset = 16'b0;
                } Reserved[31:16];
                field {
                        name = "Any_PHY_Delay";
                        desc = "FPGA IO to Marvell PHY";
                        UVM_SW_Access = "RO";
                        UVM_HW_Access = "NA";
                        reset = 16'b0;
                } Any_PHY_Delay[15:0];
        };
        reg Reserved {
                name = "Reserved";
                desc = "Reserved";
                regwidth = 32;
                accesswidth = 32;
                field {
                        name = "Reserved";
                        desc = "Added to make the address bus width 7 bits";
                        UVM_SW_Access = "RO";
                        UVM_HW_Access = "NA";
                        reset = 32'b0;
                } Reserved[31:0];
        };
// 
//=================================================================================
// Declare instances of all the registers and set their addresses
//=================================================================================
//(Component)    REG_NAME                INSTANCE_NAME               Address Offset
              STATUS_REG                STATUS_REG                 @0x00          ; 
              RESET_CTRL                RESET_CTRL                 @0x04          ; 
              DELAY_TX                  DELAY_TX                   @0x08          ; 
              DELAY_RX                  DELAY_RX                   @0x0C          ; 
              ERROR                     ERROR                      @0x10          ; 
              DR_STATUS                 DR_STATUS                  @0x14          ; 
              XCVR_MODE                 XCVR_MODE                  @0x18          ; 
              PHY0_TX_DELAY             PHY0_TX_DELAY              @0x1C          ; 
              PHY0_RX_DELAY             PHY0_RX_DELAY              @0x20          ; 
              PHY1_TX_DELAY             PHY1_TX_DELAY              @0x24          ; 
              PHY1_RX_DELAY             PHY1_RX_DELAY              @0x28          ; 
              PHY2_TX_DELAY             PHY2_TX_DELAY              @0x2C          ; 
              PHY2_RX_DELAY             PHY2_RX_DELAY              @0x30          ; 
              Reserved                  Reserved                   @0x40          ; 
// Assigning the interrupt's enable signal/register
};
